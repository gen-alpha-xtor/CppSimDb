/////////// Auto-generated from CppSim module ///////////
/////////// NOTE:  Do not modify this file! ///////////
////// Instead, modify the associated CppSim module //////

module cdr_counter(count, clk, enable_b, inc_dec);

   parameter range = 0;
   input clk;
   input enable_b;
   input inc_dec;
   output [31:0] count;

   wreal clk;
   real clk_rv;
   wreal enable_b;
   real enable_b_rv;
   wreal inc_dec;
   real inc_dec_rv;
   integer count_iv;

   assign count = count_iv;

   initial
      begin
        assign clk_rv = clk;
        assign enable_b_rv = enable_b;
        assign inc_dec_rv = inc_dec;
      end

   always
      begin
        #1
        $cdr_counter_cpp(clk_rv,enable_b_rv,inc_dec_rv,count_iv,range);
      end

endmodule
