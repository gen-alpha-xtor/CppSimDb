/////////// Auto-generated from CppSim module ///////////
/////////// NOTE:  Do not modify this file! ///////////
////// Instead, modify the associated CppSim module //////

module elem_to_vec_8(vec_out, vec_elem_0, vec_elem_1, vec_elem_2, vec_elem_3, vec_elem_4, vec_elem_5, vec_elem_6, vec_elem_7);

   parameter vec_length = 0;
   input vec_elem_0;
   input vec_elem_1;
   input vec_elem_2;
   input vec_elem_3;
   input vec_elem_4;
   input vec_elem_5;
   input vec_elem_6;
   input vec_elem_7;
   output [31:0] vec_out;

   wreal vec_elem_0;
   real vec_elem_0_rv;
   wreal vec_elem_1;
   real vec_elem_1_rv;
   wreal vec_elem_2;
   real vec_elem_2_rv;
   wreal vec_elem_3;
   real vec_elem_3_rv;
   wreal vec_elem_4;
   real vec_elem_4_rv;
   wreal vec_elem_5;
   real vec_elem_5_rv;
   wreal vec_elem_6;
   real vec_elem_6_rv;
   wreal vec_elem_7;
   real vec_elem_7_rv;
   integer vec_out_iv;

   assign vec_out = vec_out_iv;

   initial
      begin
        assign vec_elem_0_rv = vec_elem_0;
        assign vec_elem_1_rv = vec_elem_1;
        assign vec_elem_2_rv = vec_elem_2;
        assign vec_elem_3_rv = vec_elem_3;
        assign vec_elem_4_rv = vec_elem_4;
        assign vec_elem_5_rv = vec_elem_5;
        assign vec_elem_6_rv = vec_elem_6;
        assign vec_elem_7_rv = vec_elem_7;
      end

   always
      begin
        #1
        $elem_to_vec_8_cpp(vec_elem_0_rv,vec_elem_1_rv,vec_elem_2_rv,vec_elem_3_rv,vec_elem_4_rv,vec_elem_5_rv,vec_elem_6_rv,vec_elem_7_rv,vec_out_iv,vec_length);
      end

endmodule
