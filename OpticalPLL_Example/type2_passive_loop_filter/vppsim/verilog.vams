/////////// Auto-generated from CppSim module ///////////
/////////// NOTE:  Do not modify this file! ///////////
////// Instead, modify the associated CppSim module //////

module type2_passive_loop_filter(out, in);

   parameter c1 = 0.0000000000e+00;
   parameter c2 = 0.0000000000e+00;
   parameter r1 = 0.0000000000e+00;
   input in;
   output out;

   wreal in;
   real in_rv;
   wreal out;
   real out_rv;

   assign out = out_rv;

   initial
      begin
        assign in_rv = in;
      end

   always
      begin
        #1
        $type2_passive_loop_filter_cpp(in_rv,out_rv,c1,c2,r1);
      end

endmodule
