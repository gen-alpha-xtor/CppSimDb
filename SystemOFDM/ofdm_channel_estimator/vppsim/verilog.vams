/////////// Auto-generated from CppSim module ///////////
/////////// NOTE:  Do not modify this file! ///////////
////// Instead, modify the associated CppSim module //////

module ofdm_channel_estimator(vec_h_i, vec_h_mag, vec_h_phase, vec_h_q, clk_frame, vec_bit_settings, vec_in1_i, vec_in1_q, vec_in2_i, vec_in2_q);

   parameter num_channels = 0;
   parameter num_pilots = 0;
   parameter estimate = 0;
   input clk_frame;
   input [31:0] vec_bit_settings;
   input [31:0] vec_in1_i;
   input [31:0] vec_in1_q;
   input [31:0] vec_in2_i;
   input [31:0] vec_in2_q;
   output [31:0] vec_h_i;
   output [31:0] vec_h_mag;
   output [31:0] vec_h_phase;
   output [31:0] vec_h_q;

   wreal clk_frame;
   real clk_frame_rv;
   integer vec_bit_settings_iv;
   integer vec_in1_i_iv;
   integer vec_in1_q_iv;
   integer vec_in2_i_iv;
   integer vec_in2_q_iv;
   integer vec_h_i_iv;
   integer vec_h_mag_iv;
   integer vec_h_phase_iv;
   integer vec_h_q_iv;

   assign vec_h_i = vec_h_i_iv;
   assign vec_h_mag = vec_h_mag_iv;
   assign vec_h_phase = vec_h_phase_iv;
   assign vec_h_q = vec_h_q_iv;

   initial
      begin
        assign clk_frame_rv = clk_frame;
        assign vec_bit_settings_iv = vec_bit_settings;
        assign vec_in1_i_iv = vec_in1_i;
        assign vec_in1_q_iv = vec_in1_q;
        assign vec_in2_i_iv = vec_in2_i;
        assign vec_in2_q_iv = vec_in2_q;
      end

   always
      begin
        #1
        $ofdm_channel_estimator_cpp(clk_frame_rv,vec_bit_settings_iv,vec_in1_i_iv,vec_in1_q_iv,vec_in2_i_iv,vec_in2_q_iv,vec_h_i_iv,vec_h_mag_iv,vec_h_phase_iv,vec_h_q_iv,num_channels,num_pilots,estimate);
      end

endmodule
