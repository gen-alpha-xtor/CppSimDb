/////////// Auto-generated from CppSim module ///////////
/////////// NOTE:  Do not modify this file! ///////////
////// Instead, modify the associated CppSim module //////

module ofdm_transmit_serial_to_parallel(vec_bit_settings_out, vec_out, clk_data, clk_frame, in, vec_bit_settings);

   parameter num_channels = 0;
   input clk_data;
   input clk_frame;
   input [31:0] in;
   input [31:0] vec_bit_settings;
   output [31:0] vec_bit_settings_out;
   output [31:0] vec_out;

   wreal clk_data;
   real clk_data_rv;
   wreal clk_frame;
   real clk_frame_rv;
   integer in_iv;
   integer vec_bit_settings_iv;
   integer vec_bit_settings_out_iv;
   integer vec_out_iv;

   assign vec_bit_settings_out = vec_bit_settings_out_iv;
   assign vec_out = vec_out_iv;

   initial
      begin
        assign clk_data_rv = clk_data;
        assign clk_frame_rv = clk_frame;
        assign in_iv = in;
        assign vec_bit_settings_iv = vec_bit_settings;
      end

   always
      begin
        #1
        $ofdm_transmit_serial_to_parallel_cpp(clk_data_rv,clk_frame_rv,in_iv,vec_bit_settings_iv,vec_bit_settings_out_iv,vec_out_iv,num_channels);
      end

endmodule
