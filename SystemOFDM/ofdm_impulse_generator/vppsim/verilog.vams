/////////// Auto-generated from CppSim module ///////////
/////////// NOTE:  Do not modify this file! ///////////
////// Instead, modify the associated CppSim module //////

module ofdm_impulse_generator(out_i, out_q, start_sample, clk_channel, clk_frame, in_i, in_q);

   input clk_channel;
   input clk_frame;
   input in_i;
   input in_q;
   output out_i;
   output out_q;
   output [31:0] start_sample;

   wreal clk_channel;
   real clk_channel_rv;
   wreal clk_frame;
   real clk_frame_rv;
   wreal in_i;
   real in_i_rv;
   wreal in_q;
   real in_q_rv;
   wreal out_i;
   real out_i_rv;
   wreal out_q;
   real out_q_rv;
   integer start_sample_iv;

   assign out_i = out_i_rv;
   assign out_q = out_q_rv;
   assign start_sample = start_sample_iv;

   initial
      begin
        assign clk_channel_rv = clk_channel;
        assign clk_frame_rv = clk_frame;
        assign in_i_rv = in_i;
        assign in_q_rv = in_q;
      end

   always
      begin
        #1
        $ofdm_impulse_generator_cpp(clk_channel_rv,clk_frame_rv,in_i_rv,in_q_rv,out_i_rv,out_q_rv,start_sample_iv);
      end

endmodule
