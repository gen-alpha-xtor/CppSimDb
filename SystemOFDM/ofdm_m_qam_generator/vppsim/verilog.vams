/////////// Auto-generated from CppSim module ///////////
/////////// NOTE:  Do not modify this file! ///////////
////// Instead, modify the associated CppSim module //////

module ofdm_m_qam_generator(vec_bit_settings_out, vec_qam_i, vec_qam_q, clk_frame, vec_bit_settings, vec_bits);

   parameter num_channels = 0;
   input clk_frame;
   input [31:0] vec_bit_settings;
   input [31:0] vec_bits;
   output [31:0] vec_bit_settings_out;
   output [31:0] vec_qam_i;
   output [31:0] vec_qam_q;

   wreal clk_frame;
   real clk_frame_rv;
   integer vec_bit_settings_iv;
   integer vec_bits_iv;
   integer vec_bit_settings_out_iv;
   integer vec_qam_i_iv;
   integer vec_qam_q_iv;

   assign vec_bit_settings_out = vec_bit_settings_out_iv;
   assign vec_qam_i = vec_qam_i_iv;
   assign vec_qam_q = vec_qam_q_iv;

   initial
      begin
        assign clk_frame_rv = clk_frame;
        assign vec_bit_settings_iv = vec_bit_settings;
        assign vec_bits_iv = vec_bits;
      end

   always
      begin
        #1
        $ofdm_m_qam_generator_cpp(clk_frame_rv,vec_bit_settings_iv,vec_bits_iv,vec_bit_settings_out_iv,vec_qam_i_iv,vec_qam_q_iv,num_channels);
      end

endmodule
