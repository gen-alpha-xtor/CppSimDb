/////////// Auto-generated from CppSim module ///////////
/////////// NOTE:  Do not modify this file! ///////////
////// Instead, modify the associated CppSim module //////

module ofdm_ifft(vec_ifft_i, vec_ifft_q, clk_frame, vec_qam_i, vec_qam_q);

   parameter num_channels = 0;
   input clk_frame;
   input [31:0] vec_qam_i;
   input [31:0] vec_qam_q;
   output [31:0] vec_ifft_i;
   output [31:0] vec_ifft_q;

   wreal clk_frame;
   real clk_frame_rv;
   integer vec_qam_i_iv;
   integer vec_qam_q_iv;
   integer vec_ifft_i_iv;
   integer vec_ifft_q_iv;

   assign vec_ifft_i = vec_ifft_i_iv;
   assign vec_ifft_q = vec_ifft_q_iv;

   initial
      begin
        assign clk_frame_rv = clk_frame;
        assign vec_qam_i_iv = vec_qam_i;
        assign vec_qam_q_iv = vec_qam_q;
      end

   always
      begin
        #1
        $ofdm_ifft_cpp(clk_frame_rv,vec_qam_i_iv,vec_qam_q_iv,vec_ifft_i_iv,vec_ifft_q_iv,num_channels);
      end

endmodule
