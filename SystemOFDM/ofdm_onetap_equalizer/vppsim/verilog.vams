/////////// Auto-generated from CppSim module ///////////
/////////// NOTE:  Do not modify this file! ///////////
////// Instead, modify the associated CppSim module //////

module ofdm_onetap_equalizer(vec_out_i, vec_out_q, clk_frame, vec_bit_settings, vec_h_i, vec_h_q, vec_in_i, vec_in_q);

   parameter num_channels = 0;
   parameter estimate = 0;
   input clk_frame;
   input [31:0] vec_bit_settings;
   input [31:0] vec_h_i;
   input [31:0] vec_h_q;
   input [31:0] vec_in_i;
   input [31:0] vec_in_q;
   output [31:0] vec_out_i;
   output [31:0] vec_out_q;

   wreal clk_frame;
   real clk_frame_rv;
   integer vec_bit_settings_iv;
   integer vec_h_i_iv;
   integer vec_h_q_iv;
   integer vec_in_i_iv;
   integer vec_in_q_iv;
   integer vec_out_i_iv;
   integer vec_out_q_iv;

   assign vec_out_i = vec_out_i_iv;
   assign vec_out_q = vec_out_q_iv;

   initial
      begin
        assign clk_frame_rv = clk_frame;
        assign vec_bit_settings_iv = vec_bit_settings;
        assign vec_h_i_iv = vec_h_i;
        assign vec_h_q_iv = vec_h_q;
        assign vec_in_i_iv = vec_in_i;
        assign vec_in_q_iv = vec_in_q;
      end

   always
      begin
        #1
        $ofdm_onetap_equalizer_cpp(clk_frame_rv,vec_bit_settings_iv,vec_h_i_iv,vec_h_q_iv,vec_in_i_iv,vec_in_q_iv,vec_out_i_iv,vec_out_q_iv,num_channels,estimate);
      end

endmodule
