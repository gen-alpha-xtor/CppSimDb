/////////// Auto-generated from CppSim module ///////////
/////////// NOTE:  Do not modify this file! ///////////
////// Instead, modify the associated CppSim module //////

module ofdm_ber(vec_error_bits, vec_error_syms, vec_total_bits, vec_total_syms, bits_rx, bits_tx, clk_data, clk_frame, vec_bit_settings);

   parameter num_channels = 0;
   input [31:0] bits_rx;
   input [31:0] bits_tx;
   input clk_data;
   input clk_frame;
   input [31:0] vec_bit_settings;
   output [31:0] vec_error_bits;
   output [31:0] vec_error_syms;
   output [31:0] vec_total_bits;
   output [31:0] vec_total_syms;

   integer bits_rx_iv;
   integer bits_tx_iv;
   wreal clk_data;
   real clk_data_rv;
   wreal clk_frame;
   real clk_frame_rv;
   integer vec_bit_settings_iv;
   integer vec_error_bits_iv;
   integer vec_error_syms_iv;
   integer vec_total_bits_iv;
   integer vec_total_syms_iv;

   assign vec_error_bits = vec_error_bits_iv;
   assign vec_error_syms = vec_error_syms_iv;
   assign vec_total_bits = vec_total_bits_iv;
   assign vec_total_syms = vec_total_syms_iv;

   initial
      begin
        assign bits_rx_iv = bits_rx;
        assign bits_tx_iv = bits_tx;
        assign clk_data_rv = clk_data;
        assign clk_frame_rv = clk_frame;
        assign vec_bit_settings_iv = vec_bit_settings;
      end

   always
      begin
        #1
        $ofdm_ber_cpp(bits_rx_iv,bits_tx_iv,clk_data_rv,clk_frame_rv,vec_bit_settings_iv,vec_error_bits_iv,vec_error_syms_iv,vec_total_bits_iv,vec_total_syms_iv,num_channels);
      end

endmodule
