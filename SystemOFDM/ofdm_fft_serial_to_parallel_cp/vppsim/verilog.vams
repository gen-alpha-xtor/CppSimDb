/////////// Auto-generated from CppSim module ///////////
/////////// NOTE:  Do not modify this file! ///////////
////// Instead, modify the associated CppSim module //////

module ofdm_fft_serial_to_parallel_cp(vec_fft_i, vec_fft_q, clk_channel, clk_frame, serial_in_i, serial_in_q, vec_bit_settings);

   parameter num_channels = 0;
   parameter num_cp = 0;
   input clk_channel;
   input clk_frame;
   input serial_in_i;
   input serial_in_q;
   input [31:0] vec_bit_settings;
   output [31:0] vec_fft_i;
   output [31:0] vec_fft_q;

   wreal clk_channel;
   real clk_channel_rv;
   wreal clk_frame;
   real clk_frame_rv;
   wreal serial_in_i;
   real serial_in_i_rv;
   wreal serial_in_q;
   real serial_in_q_rv;
   integer vec_bit_settings_iv;
   integer vec_fft_i_iv;
   integer vec_fft_q_iv;

   assign vec_fft_i = vec_fft_i_iv;
   assign vec_fft_q = vec_fft_q_iv;

   initial
      begin
        assign clk_channel_rv = clk_channel;
        assign clk_frame_rv = clk_frame;
        assign serial_in_i_rv = serial_in_i;
        assign serial_in_q_rv = serial_in_q;
        assign vec_bit_settings_iv = vec_bit_settings;
      end

   always
      begin
        #1
        $ofdm_fft_serial_to_parallel_cp_cpp(clk_channel_rv,clk_frame_rv,serial_in_i_rv,serial_in_q_rv,vec_bit_settings_iv,vec_fft_i_iv,vec_fft_q_iv,num_channels,num_cp);
      end

endmodule
