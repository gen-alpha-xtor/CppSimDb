/////////// Auto-generated from CppSim module ///////////
/////////// NOTE:  Do not modify this file! ///////////
////// Instead, modify the associated CppSim module //////

module ofdm_remove_cyclicprefix(vec_out_i, vec_out_q, clk_frame, vec_in_i, vec_in_q);

   parameter num_channels = 0;
   parameter num_cp = 0;
   input clk_frame;
   input [31:0] vec_in_i;
   input [31:0] vec_in_q;
   output [31:0] vec_out_i;
   output [31:0] vec_out_q;

   wreal clk_frame;
   real clk_frame_rv;
   integer vec_in_i_iv;
   integer vec_in_q_iv;
   integer vec_out_i_iv;
   integer vec_out_q_iv;

   assign vec_out_i = vec_out_i_iv;
   assign vec_out_q = vec_out_q_iv;

   initial
      begin
        assign clk_frame_rv = clk_frame;
        assign vec_in_i_iv = vec_in_i;
        assign vec_in_q_iv = vec_in_q;
      end

   always
      begin
        #1
        $ofdm_remove_cyclicprefix_cpp(clk_frame_rv,vec_in_i_iv,vec_in_q_iv,vec_out_i_iv,vec_out_q_iv,num_channels,num_cp);
      end

endmodule
