/////////// Auto-generated from CppSim module ///////////
/////////// NOTE:  Do not modify this file! ///////////
////// Instead, modify the associated CppSim module //////

module ofdm_bit_source(out, clk_data, clk_frame, vec_bit_settings);

   input clk_data;
   input clk_frame;
   input [31:0] vec_bit_settings;
   output [31:0] out;

   wreal clk_data;
   real clk_data_rv;
   wreal clk_frame;
   real clk_frame_rv;
   integer vec_bit_settings_iv;
   integer out_iv;

   assign out = out_iv;

   initial
      begin
        assign clk_data_rv = clk_data;
        assign clk_frame_rv = clk_frame;
        assign vec_bit_settings_iv = vec_bit_settings;
      end

   always
      begin
        #1
        $ofdm_bit_source_cpp(clk_data_rv,clk_frame_rv,vec_bit_settings_iv,out_iv);
      end

endmodule
