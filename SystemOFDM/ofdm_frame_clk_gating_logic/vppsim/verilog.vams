/////////// Auto-generated from CppSim module ///////////
/////////// NOTE:  Do not modify this file! ///////////
////// Instead, modify the associated CppSim module //////

module ofdm_frame_clk_gating_logic(clk_frame_out, clk_frame_in);

   input clk_frame_in;
   output clk_frame_out;

   wreal clk_frame_in;
   real clk_frame_in_rv;
   wreal clk_frame_out;
   real clk_frame_out_rv;

   assign clk_frame_out = clk_frame_out_rv;

   initial
      begin
        assign clk_frame_in_rv = clk_frame_in;
      end

   always
      begin
        #1
        $ofdm_frame_clk_gating_logic_cpp(clk_frame_in_rv,clk_frame_out_rv);
      end

endmodule
