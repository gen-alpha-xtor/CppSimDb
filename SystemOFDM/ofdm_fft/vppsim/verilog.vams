/////////// Auto-generated from CppSim module ///////////
/////////// NOTE:  Do not modify this file! ///////////
////// Instead, modify the associated CppSim module //////

module ofdm_fft(vec_dqam_i, vec_dqam_q, clk_frame, vec_fft_i, vec_fft_q);

   parameter num_channels = 0;
   input clk_frame;
   input [31:0] vec_fft_i;
   input [31:0] vec_fft_q;
   output [31:0] vec_dqam_i;
   output [31:0] vec_dqam_q;

   wreal clk_frame;
   real clk_frame_rv;
   integer vec_fft_i_iv;
   integer vec_fft_q_iv;
   integer vec_dqam_i_iv;
   integer vec_dqam_q_iv;

   assign vec_dqam_i = vec_dqam_i_iv;
   assign vec_dqam_q = vec_dqam_q_iv;

   initial
      begin
        assign clk_frame_rv = clk_frame;
        assign vec_fft_i_iv = vec_fft_i;
        assign vec_fft_q_iv = vec_fft_q;
      end

   always
      begin
        #1
        $ofdm_fft_cpp(clk_frame_rv,vec_fft_i_iv,vec_fft_q_iv,vec_dqam_i_iv,vec_dqam_q_iv,num_channels);
      end

endmodule
