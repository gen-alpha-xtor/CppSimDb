/////////// Auto-generated from CppSim module ///////////
/////////// NOTE:  Do not modify this file! ///////////
////// Instead, modify the associated CppSim module //////

module mux2_intvectors(vec_out, sel, vec_in0, vec_in1);

   parameter vec_length = 0;
   input sel;
   input [31:0] vec_in0;
   input [31:0] vec_in1;
   output [31:0] vec_out;

   wreal sel;
   real sel_rv;
   integer vec_in0_iv;
   integer vec_in1_iv;
   integer vec_out_iv;

   assign vec_out = vec_out_iv;

   initial
      begin
        assign sel_rv = sel;
        assign vec_in0_iv = vec_in0;
        assign vec_in1_iv = vec_in1;
      end

   always
      begin
        #1
        $mux2_intvectors_cpp(sel_rv,vec_in0_iv,vec_in1_iv,vec_out_iv,vec_length);
      end

endmodule
