/////////// Auto-generated from CppSim module ///////////
/////////// NOTE:  Do not modify this file! ///////////
////// Instead, modify the associated CppSim module //////

module gmsk_data_generator(out, clk);

   parameter enable = 0;
   parameter data_period = 0;
   input clk;
   output out;

   wreal clk;
   real clk_rv;
   wreal out;
   real out_rv;

   assign out = out_rv;

   initial
      begin
        assign clk_rv = clk;
      end

   always
      begin
        #1
        $gmsk_data_generator_cpp(clk_rv,out_rv,enable,data_period);
      end

endmodule
