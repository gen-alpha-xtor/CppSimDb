/////////// Auto-generated from CppSim module ///////////
/////////// NOTE:  Do not modify this file! ///////////
////// Instead, modify the associated CppSim module //////

module accumulator(out, clk, in);

   parameter kph = 0.0000000000e+00;
   input clk;
   input in;
   output out;

   wreal clk;
   real clk_rv;
   wreal in;
   real in_rv;
   wreal out;
   real out_rv;

   assign out = out_rv;

   initial
      begin
        assign clk_rv = clk;
        assign in_rv = in;
      end

   always
      begin
        #1
        $accumulator_cpp(clk_rv,in_rv,out_rv,kph);
      end

endmodule
