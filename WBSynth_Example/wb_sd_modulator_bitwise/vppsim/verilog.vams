/////////// Auto-generated from CppSim module ///////////
/////////// NOTE:  Do not modify this file! ///////////
////// Instead, modify the associated CppSim module //////

module wb_sd_modulator_bitwise(out, residue, clk, in);

   parameter inbits = 0;
   parameter outbits = 0;
   input clk;
   input in;
   output out;
   output residue;

   wreal clk;
   real clk_rv;
   wreal in;
   real in_rv;
   wreal out;
   real out_rv;
   wreal residue;
   real residue_rv;

   assign out = out_rv;
   assign residue = residue_rv;

   initial
      begin
        assign clk_rv = clk;
        assign in_rv = in;
      end

   always
      begin
        #1
        $wb_sd_modulator_bitwise_cpp(clk_rv,in_rv,out_rv,residue_rv,inbits,outbits);
      end

endmodule
