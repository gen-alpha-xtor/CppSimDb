// Verilog-AMS netlist generated by the AMS netlister, version 5.10.41_USR2.19.52.
// Cadence Design Systems, Inc.

`include "disciplines.vams"

module xorpfd ( out,div,ref );

output   out;
input   div;
input   ref;

dffset (*
integer library_binding = "CppSimModules";
 *)
I4 ( .clk(
div ), .qb( net13 ), .q( net17 ), .d( xor_out ), .s( net18 ) );

xor2 (*
integer library_binding = "CppSimModules";
 *)
I3 ( .a( net27 ),
.b( net33 ), .y( xor_out ) );

nand2 (*
integer library_binding = "CppSimModules";
 *)
I8 ( .a( net11 ),
.b( net8 ), .y( out ) );
nand2 (*
integer library_binding = "CppSimModules";
 *)
I7 ( .a(
xor_out ), .b( net17 ), .y( net8 ) );

dffreset (*
integer library_binding = "CppSimModules";
 *)
I5 ( .r(
net13 ), .clk( ref ), .qb( net11 ), .q( net18 ), .d( xor_out ) );

dff2 (*
integer library_binding = "CppSimModules";
 *)
I1 ( .clk( ref ),
.qb( net24 ), .q( net27 ), .d( net24 ) );
dff2 (*
integer library_binding = "CppSimModules";
 *)
I2 ( .clk( div ),
.qb( net30 ), .q( net33 ), .d( net30 ) );

endmodule
