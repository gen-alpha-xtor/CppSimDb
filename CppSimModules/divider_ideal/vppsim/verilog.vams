/////////// Auto-generated from CppSim module ///////////
/////////// NOTE:  Do not modify this file! ///////////
////// Instead, modify the associated CppSim module //////

module divider_ideal(out, div_val, in);

   input div_val;
   input in;
   output out;

   wreal div_val;
   real div_val_rv;
   wreal in;
   real in_rv;
   wreal out;
   real out_rv;

   assign out = out_rv;

   initial
      begin
        assign div_val_rv = div_val;
        assign in_rv = in;
      end

   always
      begin
        #1
        $divider_ideal_cpp(div_val_rv,in_rv,out_rv);
      end

endmodule
