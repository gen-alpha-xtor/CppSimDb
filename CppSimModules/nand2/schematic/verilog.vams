// Verilog-AMS netlist generated by the AMS netlister, version 5.10.41_USR2.19.52.
// Cadence Design Systems, Inc.

`include "disciplines.vams"

module nand2 ( a,b,y );

input   a;
input   b;
output   y;

inv (*
integer library_binding = "CppSimModules";
 *)
I1 ( .a( net07 ),
.y( y ) );

and2 (*
integer library_binding = "CppSimModules";
 *)
I0 ( .a( a ), .b(
b ), .y( net07 ) );

endmodule
