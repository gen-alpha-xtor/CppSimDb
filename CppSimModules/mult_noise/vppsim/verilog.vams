/////////// Auto-generated from CppSim module ///////////
/////////// NOTE:  Do not modify this file! ///////////
////// Instead, modify the associated CppSim module //////

module mult_noise(out, in);

   parameter var = 0.0000000000e+00;
   input in;
   output out;

   wreal in;
   real in_rv;
   wreal out;
   real out_rv;

   assign out = out_rv;

   initial
      begin
        assign in_rv = in;
      end

   always
      begin
        #1
        $mult_noise_cpp(in_rv,out_rv,var);
      end

endmodule
