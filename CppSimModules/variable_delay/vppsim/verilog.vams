/////////// Auto-generated from CppSim module ///////////
/////////// NOTE:  Do not modify this file! ///////////
////// Instead, modify the associated CppSim module //////

module variable_delay(out, control, in);

   parameter nom_delay = 0.0000000000e+00;
   parameter control_gain = 0.0000000000e+00;
   input control;
   input in;
   output out;

   wreal control;
   real control_rv;
   wreal in;
   real in_rv;
   wreal out;
   real out_rv;

   assign out = out_rv;

   initial
      begin
        assign control_rv = control;
        assign in_rv = in;
      end

   always
      begin
        #1
        $variable_delay_cpp(control_rv,in_rv,out_rv,nom_delay,control_gain);
      end

endmodule
