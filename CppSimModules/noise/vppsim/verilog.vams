/////////// Auto-generated from CppSim module ///////////
/////////// NOTE:  Do not modify this file! ///////////
////// Instead, modify the associated CppSim module //////

module noise(out);

   parameter var = 0.0000000000e+00;
   output out;

   wreal out;
   real out_rv;

   assign out = out_rv;

   always
      begin
        #1
        $noise_cpp(out_rv,var);
      end

endmodule
