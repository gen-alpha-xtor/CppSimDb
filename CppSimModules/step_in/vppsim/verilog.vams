/////////// Auto-generated from CppSim module ///////////
/////////// NOTE:  Do not modify this file! ///////////
////// Instead, modify the associated CppSim module //////

module step_in(step);

   parameter vend = 0.0000000000e+00;
   parameter vstart = 0.0000000000e+00;
   parameter tstep = 0.0000000000e+00;
   output step;

   wreal step;
   real step_rv;

   assign step = step_rv;

   always
      begin
        #1
        $step_in_cpp(step_rv,vend,vstart,tstep);
      end

endmodule
