/////////// Auto-generated from CppSim module ///////////
/////////// NOTE:  Do not modify this file! ///////////
////// Instead, modify the associated CppSim module //////

module int_order1_mash(error, out, clk, in);

   parameter b = 0;
   parameter beta = 0;
   input clk;
   input in;
   output error;
   output out;

   wreal clk;
   real clk_rv;
   wreal in;
   real in_rv;
   wreal error;
   real error_rv;
   wreal out;
   real out_rv;

   assign error = error_rv;
   assign out = out_rv;

   initial
      begin
        assign clk_rv = clk;
        assign in_rv = in;
      end

   always
      begin
        #1
        $int_order1_mash_cpp(clk_rv,in_rv,error_rv,out_rv,b,beta);
      end

endmodule
