/////////// Auto-generated from CppSim module ///////////
/////////// NOTE:  Do not modify this file! ///////////
////// Instead, modify the associated CppSim module //////

module int_prbs_31_gen(out, clk);

   input clk;
   output out;

   wreal clk;
   real clk_rv;
   wreal out;
   real out_rv;

   assign out = out_rv;

   initial
      begin
        assign clk_rv = clk;
      end

   always
      begin
        #1
        $int_prbs_31_gen_cpp(clk_rv,out_rv);
      end

endmodule
