/////////// Auto-generated from CppSim module ///////////
/////////// NOTE:  Do not modify this file! ///////////
////// Instead, modify the associated CppSim module //////

module vco_noise(out);

   parameter noise_at_foff = 0.0000000000e+00;
   parameter foff = 0.0000000000e+00;
   parameter kv = 0.0000000000e+00;
   output out;

   wreal out;
   real out_rv;

   assign out = out_rv;

   always
      begin
        #1
        $vco_noise_cpp(out_rv,noise_at_foff,foff,kv);
      end

endmodule
