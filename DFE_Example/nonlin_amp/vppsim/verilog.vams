/////////// Auto-generated from CppSim module ///////////
/////////// NOTE:  Do not modify this file! ///////////
////// Instead, modify the associated CppSim module //////

module nonlin_amp(out, in);

   parameter a0 = 0.0000000000e+00;
   parameter a1 = 0.0000000000e+00;
   parameter a2 = 0.0000000000e+00;
   parameter a3 = 0.0000000000e+00;
   parameter min = 0.0000000000e+00;
   parameter max = 0.0000000000e+00;
   input in;
   output out;

   wreal in;
   real in_rv;
   wreal out;
   real out_rv;

   assign out = out_rv;

   initial
      begin
        assign in_rv = in;
      end

   always
      begin
        #1
        $nonlin_amp_cpp(in_rv,out_rv,a0,a1,a2,a3,min,max);
      end

endmodule
