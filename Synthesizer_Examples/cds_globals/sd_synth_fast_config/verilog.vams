// Verilog-AMS cds_globals module for top-level cell:
//      Synthesizer_Examples/sd_synth_fast.
// Generated by AMS.
// Cadence Design Systems, Inc.

`include "disciplines.vams"

module cds_globals;

endmodule
